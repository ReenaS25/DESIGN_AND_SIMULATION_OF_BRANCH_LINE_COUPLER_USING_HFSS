# Ansys Electronics Desktop project, version 2023.2
materials:
  vacuum: permittivity=1
  FR4_epoxy: permittivity=4.4 dielectric_loss_tangent=0.02
  air: permittivity=1.0006 permeability=1.0000004
  copper: permeability=0.999991 conductivity=58000000

design HFSSDesign1 (HFSS, HFSS Terminal Network, model units mm)
geometry:
  Rectangle1 = rectangle(corner=(-15mm, -20mm, 0mm), x_size=30mm, y_size=40mm)
  substrate [FR4_epoxy] = box(corner=(15mm, 20mm, 0mm), size=(-30mm, -40mm, 1.6mm))
  plane Plane1 = base (-8mm, -16mm, 0mm) normal (-2mm, -2mm, 0mm)
  Rectangle8 = rectangle(corner=(-10.05mm, -20mm, 1.6mm), z_size=-1.6mm, x_size=3mm)
  Rectangle9 = rectangle(corner=(10.05mm, -20mm, 1.6mm), z_size=-1.6mm, x_size=-3mm)
  Rectangle10 = rectangle(corner=(-10.05mm, 20mm, 1.6mm), z_size=-1.6mm, x_size=3mm)
  Rectangle11 = rectangle(corner=(10.05mm, 20mm, 1.6mm), z_size=-1.6mm, x_size=-3mm)
  Box1 [air] = box(corner=(-25mm, -35mm, -25mm), size=(50mm, 75mm, 50mm))
  HFSSDesign1_2 = component(HFSSDesign1, 3D_Component_File_Path=C:/temp/30596736170671809626)
  toppatch2 [vacuum] = part_of(HFSSDesign1_2)
  Rectangle12 = rectangle(corner=(10.05mm, -20mm, 1.6mm), z_size=-1.6mm, x_size=-3mm)
boundaries and excitations:
  HFSSDesign1_2_PerfE2: Perfect E Objects=toppatch2
  PerfE1: Perfect E Objects=Rectangle1
  Rad1: Radiation Objects=Box1
  1: Lumped Port Objects=Rectangle8 LumpedPortType=Modal Modes{Mode1{IntLine{(-8.55, -20, 0) -> (-8.55, -20, 1.6)} CharImp=Zpi}} Impedance=50ohm
  2: Lumped Port Objects=Rectangle10 LumpedPortType=Modal Modes{Mode1{IntLine{(-7.8, 20, 1.6) -> (-8.55, 20, 0)} CharImp=Zpi}} Impedance=50ohm
  3: Lumped Port Objects=Rectangle11 LumpedPortType=Modal Modes{Mode1{IntLine{(8.55, 20, 1.6) -> (8.55, 20, 0)} CharImp=Zpi}} Impedance=50ohm
  4: Lumped Port Objects=Rectangle9 LumpedPortType=Modal Modes{Mode1{IntLine{(8.55, -20, 1.6) -> (8.55, -20, 0)} CharImp=Zpi}} Impedance=50ohm
setups:
  Setup1: HfssDriven Frequency=2.4GHz MaxDeltaS=0.02 MaximumPasses=6 MinimumPasses=1 MinimumConvergedPasses=1 PercentRefinement=30 BasisOrder=1 PortAccuracy=2 DrivenSolverType="Direct Solver"
    sweep Sweep: 1GHz to 5GHz, 401 points; Type=Interpolating InterpTolerance=0.5 InterpMaxSolns=250 PassivityErrorTolerance=0.0001
  Setup2: HfssDriven Frequency=37GHz MaxDeltaS=0.02 MaximumPasses=6 MinimumPasses=1 MinimumConvergedPasses=1 PercentRefinement=30 BasisOrder=1 PortAccuracy=2 DrivenSolverType="Direct Solver"
    sweep Sweep: 1GHz to 5GHz, 401 points; Type=Interpolating InterpTolerance=0.5 InterpMaxSolns=250 PassivityErrorTolerance=0.0001
  Setup3: HfssDriven Frequency=32GHz MaxDeltaS=0.02 MaximumPasses=6 MinimumPasses=1 MinimumConvergedPasses=1 PercentRefinement=30 BasisOrder=1 PortAccuracy=2 DrivenSolverType="Direct Solver"
    sweep Sweep: 1GHz to 5GHz, 401 points; Type=Interpolating InterpTolerance=0.5 InterpMaxSolns=250 PassivityErrorTolerance=0.0001
source amplitudes:
  1:1: 1V 0deg
  2:1, 3:1, 4:1: 0V 0deg
reports:
  S Parameter Plot 1: dB(S(1,1)), dB(S(2,1)), dB(S(3,1)), dB(S(4,1)), dB(S(1,2)), dB(S(2,2)), dB(S(3,2)), dB(S(4,2)), dB(S(1,3)), dB(S(2,3)), dB(S(3,3)), dB(S(4,3)), dB(S(1,4)), dB(S(2,4)), dB(S(3,4)), dB(S(4,4)) vs Freq on Setup1 : Sweep
